ADE simulation setup
Test ee6320_2026_VCO_V1_1: ee6320_2026/03_1_VCO/schematic, simulator spectre
  Models: /home/ns25z205/cadence/EE6320_2026/modelsLibs/ibm013.scs
  Variables: l = 480n; wb = 40u; Wx = 160n; Cd = 1.26p; Co = 7f; Ibias = 8m; Ld = 300p; lt = 100p; Vb0 = 0; Vb1 = 0; Vb2 = 0; Vb3 = 0; Vb4 = 1.2; Vctrl = 0; W = 42u; Wv = 40u
  Temperature: 27
  Operating points saved: /M2 (gm)
  Analysis dc: (saves the operating point)
  Output (2 / OS("/M2" "gm")) (unticked)
  Output (freq (vtime('tran "/net9") - vtime('tran "/net5"))) (unticked)
  Output v (/Vout+ /Vout-); tran (V) = (vtime('tran "/Vout+") - vtime('tran "/Vout-"))
  Output v /Vout+; tran (V) = vtime('tran "/Vout+") (unticked)
  Output v /Vout-; tran (V) = vtime('tran "/Vout-") (unticked)
  Output output noise; dBc/Hz = rfOutputNoise("dBc/Hz" ?result "pnoise")
  Output v (/net13 /net9); tran (V) = (vtime('tran "/net13") - vtime('tran "/net9"))
Run mode: Single Run, Sweeps and Corners
