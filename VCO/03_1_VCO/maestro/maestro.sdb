ADE simulation setup
Run mode: Single Run, Sweeps and Corners
Tests:
  ee6320_2026_VCO_V1_1: ee6320_2026/03_1_VCO/schematic, simulator spectre
    Variables: Cd = 1.26p; Co = 7f; Ibias = 8m; Ld = 300p; lt = 100p; Vb0 = 0; Vb1 = 0; Vb2 = 0; Vb3 = 0; Vb4 = 1.2; Vctrl = 0; W = 42u; Wv = 40u; Wx = 160n; wb = 40u; l = 480n
    Outputs: (freq (vtime('tran "/net9") - vtime('tran "/net5")))
