ADE simulation setup
Run mode: Single Run, Sweeps and Corners
Tests:
  ee6320_2026_z_PA_testbench_V1_1: ee6320_2026/04_PA_testbench/schematic, simulator spectre
    Variables: Cb = 1n; Cd = 2p; Ibias = 3m; L = 120n; Ld = 1n; W = 120u; frf = 3.5G; Pin = 8.159
