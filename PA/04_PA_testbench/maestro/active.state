ADE simulation setup
Test ee6320_2026_z_PA_testbench_V1_1: ee6320_2026/04_PA_testbench/schematic, simulator spectre
  Models: /home/ns25z205/cadence/EE6320_2026/modelsLibs/tsmc018.scs, /home/ns25z205/cadence/EE6320_2026/modelsLibs/ibm013.scs
  Variables: frf = 3.5G; Pin = 8.159; Cb = 1n; Cd = 2p; Ibias = 3m; L = 120n; Ld = 1n; W = 120u
  Temperature: 27
  Analysis hb: sweep Pin start=-60 stop=-10 lin=200 values=("-80") fundfreqs=("(frf)") maxharms=("10") errpreset=conservative
  Output compressionCurves = compressionVRICurves((v("/net11" ?result "hb_fd") - v("/gnd" ?result "hb_fd")) '1 ?rport resultParam("PORT1:r" ?result "hb_fd") ?gcomp 1)
  Output Output Referred 1dB Compression Point = compressionVRI((v("/net11" ?result "hb_fd") - v("/gnd" ?result "hb_fd")) '1 ?rport resultParam("PORT1:r" ?result "hb_fd") ?gcomp 1 ?measure "Output")
  Output 1st Order freq = "cadar(setof(x harmonicFreqList(?result \"hb_fd\") equal(car(x) '1)))" (unticked)
Run mode: Single Run, Sweeps and Corners
