ADE simulation setup
Test ee6320_2026_LNA+Mixer_1: ee6320_2026/02_2_LNA+Mixer/schematic, simulator spectre
  Models: /home/ns25z205/cadence/EE6320_2026/modelsLibs/ibm013.scs
  Variables: prf = -40; frf2 = 3.51G; CL = 1p; del = 1.05; flo = 3.45G; frf = 3.5G; Ibias = 2m; Ld = 1.97n; Lg = 19n; Ls = 220p; Rl = 2.7k; rr = 150; VLO = 700m; W = 48u; Wb = 96u; width = 50u; m = 1
  Temperature: 27
  Analysis hb: sweep prf start=-40 stop=10 sweepStep=1 funds=("flo" "RF1" "RF2") maxharms=("3" "3" "3") errpreset=moderate
Run mode: Single Run, Sweeps and Corners
