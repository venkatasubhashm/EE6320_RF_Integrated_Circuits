ADE simulation setup
Run mode: Single Run, Sweeps and Corners
Tests:
  ee6320_2026_LNA+Mixer_1: ee6320_2026/02_2_LNA+Mixer/schematic, simulator spectre
    Variables: CL = 1p; del = 1.05; flo = 3.45G; frf = 3.5G; Ibias = 2m; Ld = 1.97n; Lg = 19n; Ls = 220p; Rl = 2.7k; rr = 150; VLO = 700m; W = 48u; Wb = 96u; width = 50u; frf2 = 3.51G; m = 1; prf = -40
