ADE simulation setup
Run mode: Single Run, Sweeps and Corners
Tests:
  ee6320_2026_Mixer_TestBench_1: ee6320_2026/02_1_Mixer_TestBench/schematic, simulator spectre
    Variables: del = 1.05; flo = 3.45G; frf1 = 3.5G; frf2 = 3.51G; Ibias = 2m; prf = -20; Rl = 2.7k; rr = 150; VLO = 700m; W = 48u; Wb = 96u
