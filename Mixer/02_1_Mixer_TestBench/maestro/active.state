ADE simulation setup
Test ee6320_2026_Mixer_TestBench_1: ee6320_2026/02_1_Mixer_TestBench/schematic, simulator spectre
  Models: /home/ns25z205/cadence/EE6320_2026/modelsLibs/ibm013.scs
  Variables: del = 1.05; flo = 3.45G; frf1 = 3.5G; frf2 = 3.51G; Ibias = 2m; prf = -20; Rl = 2.7k; rr = 150; VLO = 700m; W = 48u; Wb = 96u
  Temperature: 27
  Analysis hb: sweep prf start=-60 stop=20 sweepStep=1 funds=("flo" "frf1" "frf2") maxharms=("3" "3" "3") tstab=auto errpreset=moderate
  Output v /OUT; hbac dB20(V) = db(vh('hbac "/OUT")) (unticked)
  Output v /OUT h=-1; hbac dB20(V) = db(vh('hbac "/OUT" '-1))
  Output noise figure = getData("NF" ?result "hbnoise")
  Output Integrated Noise Figure (dB, 10KHz - 10MHz) = "10*log10(integ(getData(\"out\" ?result \"hbnoise\")**2 10K 10M)/integ(getData(\"out\" ?result \"hbnoise\")**2/(10**(getData(\"NF\" ?result \"hbnoise\")/10)) 10K 10M))" (unticked)
  Output ipnCurves = ipnVRICurves((v("/OUT" ?result "hb_mt_fi") - 0.0) '(-1 2 -1) '(-1 1 0) ?rport resultParam("PORT4:r" ?result "hb_mt_fi") ?epoint -40)
  Output Input Referred IP3 Point = ipnVRI((v("/OUT" ?result "hb_mt_fi") - 0.0) '(-1 2 -1) '(-1 1 0) ?rport resultParam("PORT4:r" ?result "hb_mt_fi") ?epoint -40)
  Output 1st Order freq = "cadar(setof(x harmonicFreqList(?result \"hb_mt_fi\") equal(car(x) '(-1 1 0))))" (unticked)
  Output Input Referred IP2 Point = ipnVRI((v("/OUT" ?result "hb_mt_fi") - 0.0) '(-1 1 1) '(-1 1 0) ?rport resultParam("PORT4:r" ?result "hb_mt_fi") ?ordspur 2 ?epoint -40)
Run mode: Single Run, Sweeps and Corners
