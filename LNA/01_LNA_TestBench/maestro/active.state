ADE simulation setup
Test ee6320_2026_LNA_TestBench_1: ee6320_2026/01_LNA_TestBench/schematic, simulator spectre
  Models: /home/ns25z205/cadence/EE6320_2026/modelsLibs/ibm013.scs
  Variables: Ls = 220p; CL = 1p; frf = 3.5G; Ld = 1.97n; Lg = 19n; prf = -40; width = 50u; m = 1
  Temperature: 27
  Analysis ac: start=1G stop=6G step=10M
  Analysis dc: (saves the operating point)
  Analysis sp: start=3.2G stop=3.8G step=10M oprobe=/PORT1 iprobe=/PORT0 ports=("/PORT0" "/PORT1") donoise=yes
  Analysis hb: sweep prf start=-60 stop=10 lin=40 funds=("RF1") maxharms=("3") tstab=auto errpreset=moderate
  Output u = db(spm('sp 1 1))
  Output S21 dB20 = db(spm('sp 2 1))
  Output NF dB10 = db10(getData("F" ?result "sp_noise"))
  Output ipnCurves = ipnVRICurves((v("/net13" ?result "hb_mt_fi") - 0.0) '(-1 2) '(0 1) ?rport resultParam("PORT1:r" ?result "hb_mt_fi"))
  Output Input Referred IP3 Point = ipnVRI((v("/net13" ?result "hb_mt_fi") - 0.0) '(-1 2) '(0 1) ?rport resultParam("PORT1:r" ?result "hb_mt_fi"))
  Output 1st Order freq = "cadar(setof(x harmonicFreqList(?result \"hb_mt_fi\") equal(car(x) '(0 1))))" (unticked)
Run mode: Single Run, Sweeps and Corners
