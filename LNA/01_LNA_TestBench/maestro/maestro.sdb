ADE simulation setup
Run mode: Single Run, Sweeps and Corners
Tests:
  ee6320_2026_LNA_TestBench_1: ee6320_2026/01_LNA_TestBench/schematic, simulator spectre
    Variables: frf = 3.5G; Ld = 1.97n; Lg = 19n; prf = -40; width = 50u; m = 1; CL = 1p; Ls = 220p
